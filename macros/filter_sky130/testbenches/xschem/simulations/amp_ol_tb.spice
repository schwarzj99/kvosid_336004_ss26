** sch_path: /foss/designs/kvosid_336004_ss26/macros/filter_sky130/testbenches/xschem/amp_ol_tb.sch
**.subckt amp_ol_tb
V3 VDD GND 1.8
VIN vid GND 0 AC 1
VIINP vip vin_p 0
VIINN vin vin_n 0
V4 di_pon GND 1.8
E7 vout GND voutp voutn 1
CL2 voutp GND 1p
xamp1 VDD vin_n vin_p voutp di_pon voutn GND amp
CL1 voutn GND 1p
x1 vid GND vip vcmi vin single2dm gain=1
V2 vcmi GND 0.9
**** begin user architecture code

.options savecurrents

.save all
.control
set doAmpSim = 1

if $doAmpSim eq 1
	setplot const
	let f_min = 10
	let f_max = 1G
	let f_stop = 500k

	let Adc = 220
	let v_step_o = 0.9
	let v_step_i = -v_step_o/Adc

	let t_rf = 0.01u
	let t_step = 5u
	let t_delay = 0
	let t_per = 2*t_step

	let tstep = 0.001*t_step
	let tstop = 2*t_per
	let tstart = t_delay

	alter @VIN[DC] = 0.0
	alter @VIN[PULSE] = [ 0 $&v_step_i $&t_delay $&t_rf $&t_rf $&t_step $&t_per 0 ]

	ac dec 100 $&const.f_min $&const.f_max

	noise v(vout) vin dec 100 $&const.f_min $&const.f_max

	tran $&tstep $&tstop $&tstart

	setplot ac1
	let Atot = v(vout)/v(vid)

	let Amag_ol_dB = vdb(Atot)
	let Aarg_ol = 180/PI*cphase(Atot)

	**let Amag_ol_dB_1 = vdb(A1)
	**let Aarg_ol_1 = 180/PI*cphase(A1)

	**let Amag_ol_dB_2 = vdb(A2)
	**let Aarg_ol_2 = 180/PI*cphase(A2)

	meas ac Adc_ol_dB max Amag_ol_dB
	let Amag_fc = Adc_ol_dB-3

	meas ac fc find frequency when Amag_ol_dB = Amag_fc
	meas ac fug_ol find frequency when Amag_ol_dB=0
	meas ac pm find Aarg_ol when frequency=fug_ol
	let pm = 180 + pm
	print pm

	let Adc_ol_lin = 10^(Adc_ol_dB/20)
	let err_gain = 1-Adc_ol_lin/(1+Adc_ol_lin)
	print err_gain*100

	plot Amag_ol_dB Aarg_ol ylabel 'Open Loop Magnitude, Phase'

	setplot noise1
	let acgain = onoise_spectrum/inoise_spectrum
	plot onoise_spectrum ylog xlog ylabel 'Output Noise'
	*plot acgain

	setplot noise2
	print onoise_total

	setplot tran2
	let vcmo = (v(voutp)+v(voutn))/2
	plot v(vin_p) v(vin_n) v(voutp) v(voutn) vcmo
end

reset
op

*rm /foss/designs/filter/dc.txt
*show >> /foss/designs/filter/dc.txt
remzerovec
write amp_ol_tb.raw
.endc

** opencircuitdesign pdks install
.lib /foss/pdks/sky130A/libs.tech/combined/sky130.lib.spice tt

.include amp_ol_tb.save

**** end user architecture code
**.ends

* expanding   symbol:  amp.sym # of pins=7
** sym_path: /foss/designs/kvosid_336004_ss26/macros/filter_sky130/schematic/xschem/amp.sym
** sch_path: /foss/designs/kvosid_336004_ss26/macros/filter_sky130/schematic/xschem/amp.sch
.subckt amp VDD VI_N VI_P VO_P di_pon VO_N VSS
*.iopin VSS
*.iopin VDD
*.ipin VI_P
*.ipin di_pon
*.ipin VI_N
*.opin VO_P
*.opin VO_N
XMP1 vbp vbp VDD VDD sky130_fd_pr__pfet_01v8 L=0.25 W='5 * 2 ' nf=2 ad='int((nf+1)/2) * W / nf * 0.29' as='int((nf+2)/2) * W / nf * 0.29'
+ pd='2*int((nf+1)/2) * (W / nf + 0.29)' ps='2*int((nf+2)/2) * (W / nf + 0.29)' nrd='0.29 / W ' nrs='0.29 / W ' sa=0 sb=0 sd=0 mult=1
XMPSW3 vbp pon VDD VDD sky130_fd_pr__pfet_01v8 L=0.15 W='5 * 5 ' nf=5 ad='int((nf+1)/2) * W / nf * 0.29' as='int((nf+2)/2) * W / nf * 0.29'
+ pd='2*int((nf+1)/2) * (W / nf + 0.29)' ps='2*int((nf+2)/2) * (W / nf + 0.29)' nrd='0.29 / W ' nrs='0.29 / W ' sa=0 sb=0 sd=0 mult=1
XMNSW1 pon_b di_pon VSS VSS sky130_fd_pr__nfet_01v8 L=0.15 W='3 * 1 ' nf=1 ad='int((nf+1)/2) * W / nf * 0.29' as='int((nf+2)/2) * W / nf * 0.29'
+ pd='2*int((nf+1)/2) * (W / nf + 0.29)' ps='2*int((nf+2)/2) * (W / nf + 0.29)' nrd='0.29 / W ' nrs='0.29 / W ' sa=0 sb=0 sd=0 mult=1
XMPSW1 pon_b di_pon VDD VDD sky130_fd_pr__pfet_01v8 L=0.15 W='5 * 1 ' nf=1 ad='int((nf+1)/2) * W / nf * 0.29' as='int((nf+2)/2) * W / nf * 0.29'
+ pd='2*int((nf+1)/2) * (W / nf + 0.29)' ps='2*int((nf+2)/2) * (W / nf + 0.29)' nrd='0.29 / W ' nrs='0.29 / W ' sa=0 sb=0 sd=0 mult=1
XMNSW2 pon pon_b VSS VSS sky130_fd_pr__nfet_01v8 L=0.15 W='3 * 3 ' nf=3 ad='int((nf+1)/2) * W / nf * 0.29' as='int((nf+2)/2) * W / nf * 0.29'
+ pd='2*int((nf+1)/2) * (W / nf + 0.29)' ps='2*int((nf+2)/2) * (W / nf + 0.29)' nrd='0.29 / W ' nrs='0.29 / W ' sa=0 sb=0 sd=0 mult=1
XMPSW2 pon pon_b VDD VDD sky130_fd_pr__pfet_01v8 L=0.15 W='5 * 3 ' nf=3 ad='int((nf+1)/2) * W / nf * 0.29' as='int((nf+2)/2) * W / nf * 0.29'
+ pd='2*int((nf+1)/2) * (W / nf + 0.29)' ps='2*int((nf+2)/2) * (W / nf + 0.29)' nrd='0.29 / W ' nrs='0.29 / W ' sa=0 sb=0 sd=0 mult=1
XMP2 viref1 vbp VDD VDD sky130_fd_pr__pfet_01v8 L=0.25 W='5 * 20 ' nf=20 ad='int((nf+1)/2) * W / nf * 0.29' as='int((nf+2)/2) * W / nf * 0.29'
+ pd='2*int((nf+1)/2) * (W / nf + 0.29)' ps='2*int((nf+2)/2) * (W / nf + 0.29)' nrd='0.29 / W ' nrs='0.29 / W ' sa=0 sb=0 sd=0 mult=1
XC5 VDD vbp sky130_fd_pr__cap_mim_m3_1 W=5 L=5 MF=5 m=5
XMP4 vo1_n VI_P viref1 viref1 sky130_fd_pr__pfet_01v8 L=0.15 W='5 * 70 ' nf=70 ad='int((nf+1)/2) * W / nf * 0.29' as='int((nf+2)/2) * W / nf * 0.29'
+ pd='2*int((nf+1)/2) * (W / nf + 0.29)' ps='2*int((nf+2)/2) * (W / nf + 0.29)' nrd='0.29 / W ' nrs='0.29 / W ' sa=0 sb=0 sd=0 mult=1
XMP5 vo1_p VI_N viref1 viref1 sky130_fd_pr__pfet_01v8 L=0.15 W='5 * 70 ' nf=70 ad='int((nf+1)/2) * W / nf * 0.29' as='int((nf+2)/2) * W / nf * 0.29'
+ pd='2*int((nf+1)/2) * (W / nf + 0.29)' ps='2*int((nf+2)/2) * (W / nf + 0.29)' nrd='0.29 / W ' nrs='0.29 / W ' sa=0 sb=0 sd=0 mult=1
XMN1 vo1_n vfb1 VSS VSS sky130_fd_pr__nfet_01v8 L=1 W='3 * 6 ' nf=6 ad='int((nf+1)/2) * W / nf * 0.29' as='int((nf+2)/2) * W / nf * 0.29'
+ pd='2*int((nf+1)/2) * (W / nf + 0.29)' ps='2*int((nf+2)/2) * (W / nf + 0.29)' nrd='0.29 / W ' nrs='0.29 / W ' sa=0 sb=0 sd=0 mult=1
XMN2 vo1_p vfb1 VSS VSS sky130_fd_pr__nfet_01v8 L=1 W='3 * 6 ' nf=6 ad='int((nf+1)/2) * W / nf * 0.29' as='int((nf+2)/2) * W / nf * 0.29'
+ pd='2*int((nf+1)/2) * (W / nf + 0.29)' ps='2*int((nf+2)/2) * (W / nf + 0.29)' nrd='0.29 / W ' nrs='0.29 / W ' sa=0 sb=0 sd=0 mult=1
XC1 vo1_n vfb1 sky130_fd_pr__cap_mim_m3_1 W=5 L=5 MF=5 m=5
XC2 vfb1 vo1_p sky130_fd_pr__cap_mim_m3_1 W=5 L=5 MF=5 m=5
XMN3 VO_N vo1_p VSS VSS sky130_fd_pr__nfet_01v8 L=0.5 W='3 * 20 ' nf=20 ad='int((nf+1)/2) * W / nf * 0.29' as='int((nf+2)/2) * W / nf * 0.29'
+ pd='2*int((nf+1)/2) * (W / nf + 0.29)' ps='2*int((nf+2)/2) * (W / nf + 0.29)' nrd='0.29 / W ' nrs='0.29 / W ' sa=0 sb=0 sd=0 mult=1
XMN4 VO_P vo1_n VSS VSS sky130_fd_pr__nfet_01v8 L=0.5 W='3 * 20 ' nf=20 ad='int((nf+1)/2) * W / nf * 0.29' as='int((nf+2)/2) * W / nf * 0.29'
+ pd='2*int((nf+1)/2) * (W / nf + 0.29)' ps='2*int((nf+2)/2) * (W / nf + 0.29)' nrd='0.29 / W ' nrs='0.29 / W ' sa=0 sb=0 sd=0 mult=1
XMP3 vbncm vbp VDD VDD sky130_fd_pr__pfet_01v8 L=0.25 W='5 * 2 ' nf=2 ad='int((nf+1)/2) * W / nf * 0.29' as='int((nf+2)/2) * W / nf * 0.29'
+ pd='2*int((nf+1)/2) * (W / nf + 0.29)' ps='2*int((nf+2)/2) * (W / nf + 0.29)' nrd='0.29 / W ' nrs='0.29 / W ' sa=0 sb=0 sd=0 mult=1
XMP6 VO_P vfb2 VDD VDD sky130_fd_pr__pfet_01v8 L=0.5 W='5 * 5 ' nf=5 ad='int((nf+1)/2) * W / nf * 0.29' as='int((nf+2)/2) * W / nf * 0.29'
+ pd='2*int((nf+1)/2) * (W / nf + 0.29)' ps='2*int((nf+2)/2) * (W / nf + 0.29)' nrd='0.29 / W ' nrs='0.29 / W ' sa=0 sb=0 sd=0 mult=1
XMP7 VO_N vfb2 VDD VDD sky130_fd_pr__pfet_01v8 L=0.5 W='5 * 5 ' nf=5 ad='int((nf+1)/2) * W / nf * 0.29' as='int((nf+2)/2) * W / nf * 0.29'
+ pd='2*int((nf+1)/2) * (W / nf + 0.29)' ps='2*int((nf+2)/2) * (W / nf + 0.29)' nrd='0.29 / W ' nrs='0.29 / W ' sa=0 sb=0 sd=0 mult=1
XC3 VO_N vfb2 sky130_fd_pr__cap_mim_m3_1 W=5 L=5 MF=5 m=5
XC4 vfb2 VO_P sky130_fd_pr__cap_mim_m3_1 W=5 L=5 MF=5 m=5
XMN5 vbncm vbncm VSS VSS sky130_fd_pr__nfet_01v8 L=0.5 W='3 * 5 ' nf=5 ad='int((nf+1)/2) * W / nf * 0.29' as='int((nf+2)/2) * W / nf * 0.29'
+ pd='2*int((nf+1)/2) * (W / nf + 0.29)' ps='2*int((nf+2)/2) * (W / nf + 0.29)' nrd='0.29 / W ' nrs='0.29 / W ' sa=0 sb=0 sd=0 mult=1
XMN6 vfb2 vbncm VSS VSS sky130_fd_pr__nfet_01v8 L=0.5 W='3 * 4 ' nf=4 ad='int((nf+1)/2) * W / nf * 0.29' as='int((nf+2)/2) * W / nf * 0.29'
+ pd='2*int((nf+1)/2) * (W / nf + 0.29)' ps='2*int((nf+2)/2) * (W / nf + 0.29)' nrd='0.29 / W ' nrs='0.29 / W ' sa=0 sb=0 sd=0 mult=1
XMNSW3 vrref_sw pon VSS VSS sky130_fd_pr__nfet_01v8 L=0.15 W='3 * 5 ' nf=5 ad='int((nf+1)/2) * W / nf * 0.29' as='int((nf+2)/2) * W / nf * 0.29'
+ pd='2*int((nf+1)/2) * (W / nf + 0.29)' ps='2*int((nf+2)/2) * (W / nf + 0.29)' nrd='0.29 / W ' nrs='0.29 / W ' sa=0 sb=0 sd=0 mult=1
XRREF vrref_sw vbp VSS sky130_fd_pr__res_xhigh_po_0p35 L=5.6 mult=1
xr1 vfb1 vo1_n vo1_p VSS rstring_cm
xr2 vfb2 VO_P VO_N VSS rstring_cm
XC6 vo1_p VO_N sky130_fd_pr__cap_mim_m3_1 W=5 L=5 MF=16 m=16
XC7 vo1_n VO_P sky130_fd_pr__cap_mim_m3_1 W=5 L=5 MF=16 m=16
.ends

* expanding   symbol:  rstring_cm.sym # of pins=4
** sym_path: /foss/designs/kvosid_336004_ss26/macros/filter_sky130/schematic/xschem/rstring_cm.sym
** sch_path: /foss/designs/kvosid_336004_ss26/macros/filter_sky130/schematic/xschem/rstring_cm.sch
.subckt rstring_cm VR_M VR_N VR_P VSS
*.iopin VSS
*.ipin VR_P
*.ipin VR_N
*.opin VR_M
XR1 VR_P net1 VSS sky130_fd_pr__res_xhigh_po_0p35 L=5.6 mult=1
XR2 net1 VR_M VSS sky130_fd_pr__res_xhigh_po_0p35 L=5.6 mult=1
XR3 VR_M net2 VSS sky130_fd_pr__res_xhigh_po_0p35 L=5.6 mult=1
XR4 net2 VR_N VSS sky130_fd_pr__res_xhigh_po_0p35 L=5.6 mult=1
.ends

.GLOBAL GND
.GLOBAL VDD
**** begin user architecture code

* from device_model attribute
.subckt single2dm vin VSS vp vcm vn gain=1
*.ipin vin
*.opin vn
*.iopin vcm
*.opin vp
*.iopin VSS
E3 vcm vn net1 VSS 'gain / 2'
E2 vp vcm net1 VSS 'gain / 2'
E1 net1 VSS vin VSS 'gain'
.ends

**** end user architecture code
.end

** sch_path: /foss/designs/kvosid_336004_ss26/macros/filter_sky130/testbenches/xschem/filter_loopgain_middlebrook_tb.sch
**.subckt filter_loopgain_middlebrook_tb
VIN vid GND 0
E4 vout1 GND voutp1 voutn1 1
VIINP vip vipp 0
VIINN vin vinn 0
R1 net1 net3 650k
R2 voutn1 net3 1.3Meg
R3 net3 vr_n 100k
C1 voutn1 vr_n 1p
C3 net3 net2 10p
R11 net1 net2 650k
R21 net2 voutp1 1.3Meg
R31 net2 vr_p 100k
C5 vr_p voutp1 1p
E5 vout GND voutp2 voutn2 1
VIOP vo_opa_n voutn1 0
VION vo_opa_p voutp1 0
E6 vr GND vr_p vr_n 1
Ixn vi_opa_n vinn dc 0 ac 0
Ixp vipp vi_opa_p dc 0 ac 0
Vxn vi_opa_n vr_p dc 0 ac 0.5 180
Vxp vi_opa_p vr_n dc 0 ac 0.5
xamp1 VDD vi_opa_n vi_opa_p vo_opa_p di_pon vo_opa_n GND amp
V3 VDD GND 1.8
V4 di_pon GND 1.8
C4 voutp2 voutn2 1p
R5 voutp1 voutp2 800k
R6 voutn1 voutn2 800k
x2 vid GND vip vcmi vin single2dm gain=1
V2 vcmi GND 0.9
**** begin user architecture code

.options savecurrents
.options method=gear reltol=.01
.options sparse
.control
save all

let f_sig = 100
let f_min = 10
let f_max = 100G
let f_stop = 5Meg
let tper_sig = 1/f_sig
let tfr_sig = tper_sig/2
* R2/R1 = 1.3Meg/650k, so beta = R1/(R1+R2) = 1/3 at dc
let Adc = 2
let beta = 1/(1+Adc)
let v_step_o = 0.9
let v_step_i = v_step_o/Adc

let t_rf = 0.1u
let t_step = 50u
let t_delay = 0
let t_per = 2*t_step

let tstep = 0.1*t_rf
let tstop = 2*t_per
let tstart = t_delay

*alter @VIN[SIN] = [ 0 0.01 $&f_sig 0 0 0 ]
alter @VIN[DC] = 0.0

set wr_singlescale
set wr_vecnames
option numdgt=3

** Main Simulations
	* The loop is cut at the amplifier inputs. Vxp and Vxn sit in series between the summing
	* nodes vr_n, vr_p and the gates, Ixp and Ixn inject into the gates, both differentially.
	op

	* run 1, voltage injection: the probe sources carry +-0.5 V, the probe currents are off
	ac dec 100 $&const.f_min $&const.f_max
	let va1 = v(vi_opa_p) - v(vi_opa_n)
	let vb1 = v(vr_n) - v(vr_p)
	let i1 = (i(Vxp) - i(Vxn))/2

	* run 2, current injection: the probe currents carry 1 A differential, the probe sources are off
	alter @Vxp[acmag] = 0
	alter @Vxn[acmag] = 0
	alter @Ixp[acmag] = 1
	alter @Ixn[acmag] = 1
	ac dec 100 $&const.f_min $&const.f_max
	let va2 = v(vi_opa_p) - v(vi_opa_n)
	let i2 = (i(Vxp) - i(Vxn))/2

	* Middlebrook 1975: the voltage and the current loop gain at the cut, exact when nothing flows back through it
	let Tv = -ac1.vb1/ac1.va1
	let Ti = i2/(1 - i2)
	let L = (Tv*Ti - 1)/(Tv + Ti + 2)

	let A = L/beta

	let L_re = real(L)
	let L_im = imag(L)

	let L_dB = vdb(L)
	let L_arg = 180/PI*cphase(L)
	let A_dB = vdb(A)
	let A_arg = 180/PI*cphase(A)

	let fdc = const.f_min+1

	meas ac fug find frequency when L_dB=0
	meas ac pm find L_arg when frequency=fug
	meas ac L_im_zero find L_im when L_re=0

	let pm = 180-abs(pm)

	print pm

	* gain margin, and how close the Nyquist curve comes to -1 anywhere
	meas ac L180_dB find L_dB when L_arg=-180
	let gm = -L180_dB
	print gm
	let L_dist = mag(1+L)
	meas ac dist_min min L_dist
	print dist_min

	meas ac L0_dB find L_dB when frequency = fdc
	let err_gain = 1/(1+10^(L0_dB/20))

	print err_gain

	plot L_dB L_arg A_dB A_arg title 'Bode Plot of Loop Gain' ylabel 'Magnitude (dB) / Phase (Deg)'
	plot L_im vs L_re retraceplot title 'Nyquist Plot of Loop Gain' ylabel 'Imaginary Part' xlabel 'Real Part'

alter @VIN[DC] = 0
op

remzerovec
write filter_loopgain_middlebrook_tb.raw
.endc

.include filter_loopgain_middlebrook_tb.save

** opencircuitdesign pdks install
.lib /foss/pdks/sky130A/libs.tech/combined/sky130.lib.spice tt

**** end user architecture code
**.ends

* expanding   symbol:  amp.sym # of pins=7
** sym_path: /foss/designs/kvosid_336004_ss26/macros/filter_sky130/schematic/xschem/amp.sym
** sch_path: /foss/designs/kvosid_336004_ss26/macros/filter_sky130/schematic/xschem/amp.sch
.subckt amp VDD VI_N VI_P VO_P di_pon VO_N VSS
*.iopin VSS
*.iopin VDD
*.ipin VI_P
*.ipin di_pon
*.ipin VI_N
*.opin VO_P
*.opin VO_N
XMP1 vbp vbp VDD VDD sky130_fd_pr__pfet_01v8 L=0.25 W='5 * 2 ' nf=2 ad='int((nf+1)/2) * W / nf * 0.29' as='int((nf+2)/2) * W / nf * 0.29'
+ pd='2*int((nf+1)/2) * (W / nf + 0.29)' ps='2*int((nf+2)/2) * (W / nf + 0.29)' nrd='0.29 / W ' nrs='0.29 / W ' sa=0 sb=0 sd=0 mult=1
XMPSW3 vbp pon VDD VDD sky130_fd_pr__pfet_01v8 L=0.15 W='5 * 5 ' nf=5 ad='int((nf+1)/2) * W / nf * 0.29' as='int((nf+2)/2) * W / nf * 0.29'
+ pd='2*int((nf+1)/2) * (W / nf + 0.29)' ps='2*int((nf+2)/2) * (W / nf + 0.29)' nrd='0.29 / W ' nrs='0.29 / W ' sa=0 sb=0 sd=0 mult=1
XMNSW1 pon_b di_pon VSS VSS sky130_fd_pr__nfet_01v8 L=0.15 W='3 * 1 ' nf=1 ad='int((nf+1)/2) * W / nf * 0.29' as='int((nf+2)/2) * W / nf * 0.29'
+ pd='2*int((nf+1)/2) * (W / nf + 0.29)' ps='2*int((nf+2)/2) * (W / nf + 0.29)' nrd='0.29 / W ' nrs='0.29 / W ' sa=0 sb=0 sd=0 mult=1
XMPSW1 pon_b di_pon VDD VDD sky130_fd_pr__pfet_01v8 L=0.15 W='5 * 1 ' nf=1 ad='int((nf+1)/2) * W / nf * 0.29' as='int((nf+2)/2) * W / nf * 0.29'
+ pd='2*int((nf+1)/2) * (W / nf + 0.29)' ps='2*int((nf+2)/2) * (W / nf + 0.29)' nrd='0.29 / W ' nrs='0.29 / W ' sa=0 sb=0 sd=0 mult=1
XMNSW2 pon pon_b VSS VSS sky130_fd_pr__nfet_01v8 L=0.15 W='3 * 3 ' nf=3 ad='int((nf+1)/2) * W / nf * 0.29' as='int((nf+2)/2) * W / nf * 0.29'
+ pd='2*int((nf+1)/2) * (W / nf + 0.29)' ps='2*int((nf+2)/2) * (W / nf + 0.29)' nrd='0.29 / W ' nrs='0.29 / W ' sa=0 sb=0 sd=0 mult=1
XMPSW2 pon pon_b VDD VDD sky130_fd_pr__pfet_01v8 L=0.15 W='5 * 3 ' nf=3 ad='int((nf+1)/2) * W / nf * 0.29' as='int((nf+2)/2) * W / nf * 0.29'
+ pd='2*int((nf+1)/2) * (W / nf + 0.29)' ps='2*int((nf+2)/2) * (W / nf + 0.29)' nrd='0.29 / W ' nrs='0.29 / W ' sa=0 sb=0 sd=0 mult=1
XMP2 viref1 vbp VDD VDD sky130_fd_pr__pfet_01v8 L=0.25 W='5 * 20 ' nf=20 ad='int((nf+1)/2) * W / nf * 0.29' as='int((nf+2)/2) * W / nf * 0.29'
+ pd='2*int((nf+1)/2) * (W / nf + 0.29)' ps='2*int((nf+2)/2) * (W / nf + 0.29)' nrd='0.29 / W ' nrs='0.29 / W ' sa=0 sb=0 sd=0 mult=1
XC5 VDD vbp sky130_fd_pr__cap_mim_m3_1 W=5 L=5 MF=5 m=5
XMP4 vo1_n VI_P viref1 viref1 sky130_fd_pr__pfet_01v8 L=0.15 W='5 * 70 ' nf=70 ad='int((nf+1)/2) * W / nf * 0.29' as='int((nf+2)/2) * W / nf * 0.29'
+ pd='2*int((nf+1)/2) * (W / nf + 0.29)' ps='2*int((nf+2)/2) * (W / nf + 0.29)' nrd='0.29 / W ' nrs='0.29 / W ' sa=0 sb=0 sd=0 mult=1
XMP5 vo1_p VI_N viref1 viref1 sky130_fd_pr__pfet_01v8 L=0.15 W='5 * 70 ' nf=70 ad='int((nf+1)/2) * W / nf * 0.29' as='int((nf+2)/2) * W / nf * 0.29'
+ pd='2*int((nf+1)/2) * (W / nf + 0.29)' ps='2*int((nf+2)/2) * (W / nf + 0.29)' nrd='0.29 / W ' nrs='0.29 / W ' sa=0 sb=0 sd=0 mult=1
XMN1 vo1_n vfb1 VSS VSS sky130_fd_pr__nfet_01v8 L=1 W='3 * 6 ' nf=6 ad='int((nf+1)/2) * W / nf * 0.29' as='int((nf+2)/2) * W / nf * 0.29'
+ pd='2*int((nf+1)/2) * (W / nf + 0.29)' ps='2*int((nf+2)/2) * (W / nf + 0.29)' nrd='0.29 / W ' nrs='0.29 / W ' sa=0 sb=0 sd=0 mult=1
XMN2 vo1_p vfb1 VSS VSS sky130_fd_pr__nfet_01v8 L=1 W='3 * 6 ' nf=6 ad='int((nf+1)/2) * W / nf * 0.29' as='int((nf+2)/2) * W / nf * 0.29'
+ pd='2*int((nf+1)/2) * (W / nf + 0.29)' ps='2*int((nf+2)/2) * (W / nf + 0.29)' nrd='0.29 / W ' nrs='0.29 / W ' sa=0 sb=0 sd=0 mult=1
XC1 vo1_n vfb1 sky130_fd_pr__cap_mim_m3_1 W=5 L=5 MF=5 m=5
XC2 vfb1 vo1_p sky130_fd_pr__cap_mim_m3_1 W=5 L=5 MF=5 m=5
XMN3 VO_N vo1_p VSS VSS sky130_fd_pr__nfet_01v8 L=0.5 W='3 * 20 ' nf=20 ad='int((nf+1)/2) * W / nf * 0.29' as='int((nf+2)/2) * W / nf * 0.29'
+ pd='2*int((nf+1)/2) * (W / nf + 0.29)' ps='2*int((nf+2)/2) * (W / nf + 0.29)' nrd='0.29 / W ' nrs='0.29 / W ' sa=0 sb=0 sd=0 mult=1
XMN4 VO_P vo1_n VSS VSS sky130_fd_pr__nfet_01v8 L=0.5 W='3 * 20 ' nf=20 ad='int((nf+1)/2) * W / nf * 0.29' as='int((nf+2)/2) * W / nf * 0.29'
+ pd='2*int((nf+1)/2) * (W / nf + 0.29)' ps='2*int((nf+2)/2) * (W / nf + 0.29)' nrd='0.29 / W ' nrs='0.29 / W ' sa=0 sb=0 sd=0 mult=1
XMP3 vbncm vbp VDD VDD sky130_fd_pr__pfet_01v8 L=0.25 W='5 * 2 ' nf=2 ad='int((nf+1)/2) * W / nf * 0.29' as='int((nf+2)/2) * W / nf * 0.29'
+ pd='2*int((nf+1)/2) * (W / nf + 0.29)' ps='2*int((nf+2)/2) * (W / nf + 0.29)' nrd='0.29 / W ' nrs='0.29 / W ' sa=0 sb=0 sd=0 mult=1
XMP6 VO_P vfb2 VDD VDD sky130_fd_pr__pfet_01v8 L=0.5 W='5 * 5 ' nf=5 ad='int((nf+1)/2) * W / nf * 0.29' as='int((nf+2)/2) * W / nf * 0.29'
+ pd='2*int((nf+1)/2) * (W / nf + 0.29)' ps='2*int((nf+2)/2) * (W / nf + 0.29)' nrd='0.29 / W ' nrs='0.29 / W ' sa=0 sb=0 sd=0 mult=1
XMP7 VO_N vfb2 VDD VDD sky130_fd_pr__pfet_01v8 L=0.5 W='5 * 5 ' nf=5 ad='int((nf+1)/2) * W / nf * 0.29' as='int((nf+2)/2) * W / nf * 0.29'
+ pd='2*int((nf+1)/2) * (W / nf + 0.29)' ps='2*int((nf+2)/2) * (W / nf + 0.29)' nrd='0.29 / W ' nrs='0.29 / W ' sa=0 sb=0 sd=0 mult=1
XC3 VO_N vfb2 sky130_fd_pr__cap_mim_m3_1 W=5 L=5 MF=5 m=5
XC4 vfb2 VO_P sky130_fd_pr__cap_mim_m3_1 W=5 L=5 MF=5 m=5
XMN5 vbncm vbncm VSS VSS sky130_fd_pr__nfet_01v8 L=0.5 W='3 * 5 ' nf=5 ad='int((nf+1)/2) * W / nf * 0.29' as='int((nf+2)/2) * W / nf * 0.29'
+ pd='2*int((nf+1)/2) * (W / nf + 0.29)' ps='2*int((nf+2)/2) * (W / nf + 0.29)' nrd='0.29 / W ' nrs='0.29 / W ' sa=0 sb=0 sd=0 mult=1
XMN6 vfb2 vbncm VSS VSS sky130_fd_pr__nfet_01v8 L=0.5 W='3 * 4 ' nf=4 ad='int((nf+1)/2) * W / nf * 0.29' as='int((nf+2)/2) * W / nf * 0.29'
+ pd='2*int((nf+1)/2) * (W / nf + 0.29)' ps='2*int((nf+2)/2) * (W / nf + 0.29)' nrd='0.29 / W ' nrs='0.29 / W ' sa=0 sb=0 sd=0 mult=1
XMNSW3 vrref_sw pon VSS VSS sky130_fd_pr__nfet_01v8 L=0.15 W='3 * 5 ' nf=5 ad='int((nf+1)/2) * W / nf * 0.29' as='int((nf+2)/2) * W / nf * 0.29'
+ pd='2*int((nf+1)/2) * (W / nf + 0.29)' ps='2*int((nf+2)/2) * (W / nf + 0.29)' nrd='0.29 / W ' nrs='0.29 / W ' sa=0 sb=0 sd=0 mult=1
XRREF vrref_sw vbp VSS sky130_fd_pr__res_xhigh_po_0p35 L=5.6 mult=1
xr1 vfb1 vo1_n vo1_p VSS rstring_cm
xr2 vfb2 VO_P VO_N VSS rstring_cm
XC6 vo1_p VO_N sky130_fd_pr__cap_mim_m3_1 W=5 L=5 MF=16 m=16
XC7 vo1_n VO_P sky130_fd_pr__cap_mim_m3_1 W=5 L=5 MF=16 m=16
.ends

* expanding   symbol:  rstring_cm.sym # of pins=4
** sym_path: /foss/designs/kvosid_336004_ss26/macros/filter_sky130/schematic/xschem/rstring_cm.sym
** sch_path: /foss/designs/kvosid_336004_ss26/macros/filter_sky130/schematic/xschem/rstring_cm.sch
.subckt rstring_cm VR_M VR_N VR_P VSS
*.iopin VSS
*.ipin VR_P
*.ipin VR_N
*.opin VR_M
XR1 VR_P net1 VSS sky130_fd_pr__res_xhigh_po_0p35 L=5.6 mult=1
XR2 net1 VR_M VSS sky130_fd_pr__res_xhigh_po_0p35 L=5.6 mult=1
XR3 VR_M net2 VSS sky130_fd_pr__res_xhigh_po_0p35 L=5.6 mult=1
XR4 net2 VR_N VSS sky130_fd_pr__res_xhigh_po_0p35 L=5.6 mult=1
.ends

.GLOBAL GND
.GLOBAL VDD
**** begin user architecture code

* from device_model attribute
.subckt single2dm vin VSS vp vcm vn gain=1
*.ipin vin
*.opin vn
*.iopin vcm
*.opin vp
*.iopin VSS
E3 vcm vn net1 VSS 'gain / 2'
E2 vp vcm net1 VSS 'gain / 2'
E1 net1 VSS vin VSS 'gain'
.ends

**** end user architecture code
.end

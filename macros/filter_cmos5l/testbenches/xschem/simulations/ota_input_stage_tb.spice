** sch_path: /foss/designs/kvosid/macros/filter_cmos5l/testbenches/xschem/ota_input_stage_tb.sch
**.subckt ota_input_stage_tb
V2 vcmi GND 0.75
VIN vid GND 0 AC 1
VIINP vip vipp 0
VIINN vin vinn 0
E5 vout GND voutp1 voutn1 1
VIOP net1 voutn1 0
VION net2 voutp1 0
x1 vid GND vip vcmi vin single2dm gain=1
xamp1 VDD vinn vipp net2 net1 GND amp_input_stage
VDD VDD GND 1.5
**** begin user architecture code

.include ota_input_stage_tb.save
.options savecurrents
.options method=gear reltol=.005
.options sparse
.control
save all

let f_sig = 100
let f_min = 10
let f_max = 1000Meg
let f_stop = 5Meg
let tper_sig = 1/f_sig
let tfr_sig = tper_sig/2
let Adc = 4000
let v_step_o = 0.75
let v_step_i = v_step_o/Adc

let t_rf = 0.1u
let t_step = 50u
let t_delay = 0
let t_per = 2*t_step

let tstep = 0.1*t_rf
let tstop = 2*t_per
let tstart = t_delay

alter @VIN[PULSE] = [ 0 $&v_step_i $&t_delay $&t_rf $&t_rf $&t_step $&t_per 0 ]

set wr_singlescale
set wr_vecnames
option numdgt=3

** Main Simulations
	op
	ac dec 100 $&const.f_min $&const.f_max
	tran $&tstep $&tstop $&tstart

	setplot ac1
	let A = v(vout)/v(vid)

	let Amag_dB = vdb(A)
	settype decibel Amag_dB
	let Aarg = 180/PI*cphase(A)

	let fdc = const.f_min+1
	meas ac Adc find Amag_dB when frequency = fdc
	let Amag_fc = Adc-3
	meas ac fc find frequency when Amag_dB = Amag_fc
	meas ac Amax max Amag_dB
	meas ac fug find frequency when Amag_dB=0

	let Adc_lin = 10^(Adc/20)
	let GBW = Adc_lin*fc
	print Adc_lin
	print GBW

	plot Amag_dB Aarg ylabel 'Magnitude, Phase'

	setplot tran1
	let vid = v(vid)
	let iop = viop#branch
	let ion = vion#branch
	let vcmo = (voutp1+voutn1)/2

	*plot iop ion
	plot vid vout vcmo
	plot v(vip) v(vin) v(voutp1) v(voutn1) vcmo

alter @VIN[DC] = 0
op

remzerovec
write ota_input_stage_tb.raw
.endc

.lib cornerMOSlv.lib mos_tt
.lib cornerMOShv.lib mos_tt
.lib cornerRES.lib res_typ
.lib cornerDIO.lib dio_tt

**** end user architecture code
**.ends

* expanding   symbol:  amp_input_stage.sym # of pins=6
** sym_path: /foss/designs/kvosid/macros/filter_cmos5l/schematic/xschem/amp_input_stage.sym
** sch_path: /foss/designs/kvosid/macros/filter_cmos5l/schematic/xschem/amp_input_stage.sch
.subckt amp_input_stage VDD VI_N VI_P VO_P VO_N VSS
*.iopin VSS
*.iopin VDD
*.ipin VI_P
*.ipin VI_N
*.opin VO_N
*.opin VO_P
XM12 VO_N vfb1 VSS VSS sg13_lv_nmos w=4u l=0.5u ng=8 m=1 mm_ok=1
XM13 VO_P vfb1 VSS VSS sg13_lv_nmos w=4u l=0.5u ng=8 m=1 mm_ok=1
XM18 VO_N VI_P viref1 viref1 sg13_lv_pmos w=48.5u l=0.13u ng=10 m=1 mm_ok=1
XM19 VO_P VI_N viref1 viref1 sg13_lv_pmos w=48.5u l=0.13u ng=10 m=1 mm_ok=1
I0 VDD viref1 520u
xr1 vfb1 VO_N VO_P VSS rstring_cm
.ends

* expanding   symbol:  rstring_cm.sym # of pins=4
** sym_path: /foss/designs/kvosid/macros/filter_cmos5l/schematic/xschem/rstring_cm.sym
** sch_path: /foss/designs/kvosid/macros/filter_cmos5l/schematic/xschem/rstring_cm.sch
.subckt rstring_cm VR_M VR_N VR_P VSS
*.iopin VSS
*.ipin VR_P
*.ipin VR_N
*.opin VR_M
R1 VR_P VR_M 100k
R4 VR_M VR_N 100k
.ends

.GLOBAL GND
**** begin user architecture code

* from device_model attribute
.subckt single2dm vin VSS vp vcm vn gain=1
*.ipin vin
*.opin vn
*.iopin vcm
*.opin vp
*.iopin VSS
E3 vcm vn net1 VSS 'gain / 2'
E2 vp vcm net1 VSS 'gain / 2'
E1 net1 VSS vin VSS 'gain'
.ends

**** end user architecture code
.end

.param W_REF=260n
.param L_REF=750n
.param NG_REF=1
.param W_TAIL=2.86u
.param L_TAIL=750n
.param NG_TAIL=11
.param W_DP=5.16u
.param L_DP=500n
.param NG_DP=1
.param W_LD1=2.76u
.param L_LD1=1u
.param NG_LD1=4
.param W_CS2=8.97u
.param L_CS2=1u
.param NG_CS2=13
.param W_LD2=1.74u
.param L_LD2=500n
.param NG_LD2=1
.param W_RREF=500n
.param L_RREF=1.8795m
.param C_C=5.015p
